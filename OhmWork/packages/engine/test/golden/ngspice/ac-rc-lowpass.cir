* AC: RC low-pass, 1 kOhm and 1 uF (corner 159.155 Hz). Gain and phase of v(out) / v(in).
* Results vdb, vp(rad): 10 Hz -1.71115e-02, -6.27494e-02; 159.155 Hz -3.01030, -7.85398e-01; 10 kHz -3.59647e+01, -1.55488
Vin in 0 AC 1
R1 in out 1k
C1 out 0 1u
.control
ac lin 1 10 10
print vdb(out) vp(out)
ac lin 1 159.155 159.155
print vdb(out) vp(out)
ac lin 1 10k 10k
print vdb(out) vp(out)
.endc
.end
